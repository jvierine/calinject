Calinject fixed_pad
V1 src 0 AC 1
Rs src in 50
C1 in a 1.0000000000000001e-07
Ra a 0 61.9
Rb a out 249.0
Rc out 0 61.9
Rl out 0 50
.control
set wr_singlescale
set wr_vecnames
ac dec 100 500k 70meg
wrdata /Users/jvi019/src/calinject/validation/simulation/fixed_pad.txt v(a) v(out)
quit
.endc
.end
